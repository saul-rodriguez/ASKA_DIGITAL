ADE simulation setup
Run mode: Single Run, Sweeps and Corners
Tests:
  ASKA_DIG2:DIG_stimulus_tb:1: ASKA_DIG2/DIG_stimulus_tb/config, simulator ams
Global variables:
  ADDR_0 = 0
  ADDR_1 = 0
