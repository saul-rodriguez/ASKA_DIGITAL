ADE simulation setup
Run mode: Single Run, Sweeps and Corners
Tests:
  Long: ASKA_DIG/DIG_stimulus_tb/config, simulator ams
  short (off): ASKA_DIG/DIG_stimulus_tb/config, simulator ams
Global variables:
  ADDR_0 = 0
  ADDR_1 = 0
